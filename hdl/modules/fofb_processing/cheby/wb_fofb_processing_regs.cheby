memory-map:
  bus: wb-32-be
  name: wb_fofb_processing_regs
  description: interface to internal regs
  x-hdl:
    busgroup: True
  children:
    - block:
        name: fixed_point_pos
        description: fofb processing fixed-point position constants
        size: 64
        address: 0x00000000
        children:
        - reg:
            name: coeff
            width: 32
            access: ro
            address: next
            description: fofb processing coefficients fixed-point position constant
            children:
              - field:
                  name: val
                  range: 31-0
                  description: fixed-point position constant value
        - reg:
            name: accs_gains
            width: 32
            access: ro
            address: next
            description: fofb processing accumulators' gains fixed-point position register
            children:
              - field:
                  name: val
                  range: 31-0
                  description: value
    - block:
        name: loop_intlk
        description: fofb processing loop interlock registers
        size: 64
        children:
        - reg:
            name: ctl
            width: 32
            access: rw
            address: next
            description: fofb processing loop interlock control register
            children:
              - field:
                  name: sta_clr
                  x-hdl:
                    type: autoclear
                  range: 0
                  description: clears loop interlock status
                  comment: |
                    write 0: no effect
                    write 1: clears loop interlock status (this bit autoclears)
              - field:
                  name: src_en_orb_distort
                  range: 1
                  description: orbit distortion source enable
                  comment: |
                    write 0: disables source
                    write 1: enables source
              - field:
                  name: src_en_packet_loss
                  range: 2
                  description: packet loss source enable
                  comment: |
                    write 0: disables source
                    write 1: enables source
        - reg:
            name: sta
            width: 32
            access: ro
            address: next
            description: fofb processing loop interlock status register
            children:
              - field:
                  name: orb_distort
                  range: 0
                  description: orbit distortion loop interlock flag
                  comment: |
                    read 0: not interlocked
                    read 1: interlocked
              - field:
                  name: packet_loss
                  range: 1
                  description: packet loss loop interlock flag
                  comment: |
                    read 0: not interlocked
                    read 1: interlocked
        - reg:
            name: orb_distort_limit
            width: 32
            access: rw
            address: next
            description: fofb processing loop interlock orbit distortion limit value register
            children:
              - field:
                  name: val
                  range: 31-0
                  description: value
        - reg:
            name: min_num_pkts
            width: 32
            access: rw
            address: next
            description: fofb processing loop interlock minimum number of packets per timeframe value register
            children:
              - field:
                  name: val
                  range: 31-0
                  description: value
    - memory:
        name: sps_ram_bank
        memsize: 2k
        address: next
        description: fofb processing setpoints ram bank
        children:
          - reg:
              name: data
              width: 32
              access: rw
    - repeat:
        name: ch
        count: 12
        size: 4096
        align : False
        children:
          - memory:
              name: coeff_ram_bank
              memsize: 2k
              description: fofb processing coefficients ram bank (per channel)
              children:
                - reg:
                    name: data
                    width: 32
                    access: rw
          - block:
              name: acc
              description: fofb processing accumulator registers (per channel)
              size: 64
              children:
              - reg:
                  name: ctl
                  width: 32
                  access: rw
                  description: fofb processing accumulator control register (per channel)
                  children:
                    - field:
                        name: clear
                        x-hdl:
                          type: autoclear
                        range: 0
                        description: clear accumulator bit
                        comment: |
                          write 0: no effect
                          write 1: clears accumulator (this bit autoclears)
                    - field:
                        name: freeze
                        range: 1
                        description: freeze accumulator bit
                        comment: |
                          write 0: no effect on accumulator
                          write 1: freezes accumulator
              - reg:
                  name: gain
                  width: 32
                  access: rw
                  description: fofb processing accumulator gain register (per channel)
                  children:
                    - field:
                        name: val
                        range: 31-0
                        description: value
          - block:
              name: sp_limits
              description: fofb processing saturation limits registers (per channel)
              align: False
              children:
              - reg:
                  name: max
                  width: 32
                  access: rw
                  description: fofb processing maximum saturation value register (per channel)
                  children:
                    - field:
                        name: val
                        range: 31-0
                        description: value
              - reg:
                  name: min
                  width: 32
                  access: rw
                  description: fofb processing minimum saturation value register (per channel)
                  children:
                    - field:
                        name: val
                        range: 31-0
                        description: value
