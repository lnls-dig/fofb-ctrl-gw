memory-map:
  bus: wb-32-be
  name: fofb_cc_csr
  description: FOFB CC registers
  comment: |
    Wishbone slave for FOFB CC core
  x-hdl:
    busgroup: True
    iogroup: fofb_cc_csr
  x-wbgen:
    hdl_entity: wb_fofb_cc_csr
  children:
    - reg:
        name: cfg_val
        address: 0x00000000
        width: 32
        access: rw
        description: FOFB CC configuration register
        comment: |
          FOFB CC configuration register
        children:
          - field:
              name: act_part
              range: 0
              description: signals FOFB CC module to read configuration RAM
              comment: |
                write 1: trigger a new read to configuration RAM
              x-wbgen:
                type: MONOSTABLE
                clock: fofb_cc_clk_ram_reg_i
          - field:
              name: unused
              range: 1
              description: unused
              comment: |
                unused
              x-wbgen:
                clock: fofb_cc_clk_ram_reg_i
                type: BIT
          - field:
              name: err_clr
              range: 2
              description: clears gigabit transceiver errors
              comment: |
                write 1: clears gigabit transceiver errors
              x-wbgen:
                type: MONOSTABLE
                clock: fofb_cc_clk_ram_reg_i
          - field:
              name: cc_enable
              range: 3
              description: enables CC module
              comment: |
                write 1: enables CC module
                write 0: disables CC module (acts as reset)
              x-wbgen:
                clock: fofb_cc_clk_ram_reg_i
                type: BIT
          - field:
              name: tfs_override
              range: 4
              description: >-
                timeframe start override.
                BPM can override internal timeframe start signal and use MGT generated one.
              comment: |
                write 1: overrides timeframe start. BPM uses external signal.
                write 0: normal operation. BPM uses internal generated signal.
              x-wbgen:
                clock: fofb_cc_clk_ram_reg_i
                type: BIT
    - memory:
        name: ram_reg
        memsize: 8k
        address: 0x00002000
        description: FOFB CC RAM for register map
        comment: |
          Register map is hanlded inside the FOFC CC module, but the RAM to read/write
          to/from the signals are instantiated outside.
        align: True
        x-wbgen:
          kind: ram
          access_dev: READ_WRITE
          clock: fofb_cc_clk_ram_reg_i
        children:
          - reg:
              name: data
              width: 32
              access: rw
