memory-map:
  bus: wb-32-be
  name: fofb_cc_regs
  description: FOFB CC registers
  comment: |
    Wishbone slave for FOFB CC core
  x-hdl:
    busgroup: True
    iogroup: fofb_cc_regs
  x-wbgen:
    hdl_entity: wb_fofb_cc_regs
  children:
    - reg:
        name: cfg_val
        address: 0x00000000
        width: 32
        access: rw
        description: FOFB CC configuration register
        comment: |
          FOFB CC configuration register
        children:
          - field:
              name: act_part
              range: 0
              description: signals FOFB CC module to read configuration RAM
              comment: |
                write 1: trigger a new read to configuration RAM
              x-wbgen:
                type: MONOSTABLE
                clock: fofb_cc_clk_ram_reg_i
          - field:
              name: unused
              range: 1
              description: unused
              comment: |
                unused
              x-wbgen:
                clock: fofb_cc_clk_ram_reg_i
                type: BIT
          - field:
              name: err_clr
              range: 2
              description: clears gigabit transceiver errors
              comment: |
                write 1: clears gigabit transceiver errors
              x-wbgen:
                type: MONOSTABLE
                clock: fofb_cc_clk_ram_reg_i
          - field:
              name: cc_enable
              range: 3
              description: enables CC module
              comment: |
                write 1: enables CC module
                write 0: disables CC module (acts as reset)
              x-wbgen:
                clock: fofb_cc_clk_ram_reg_i
                type: BIT
          - field:
              name: tfs_override
              range: 4
              description: >-
                timeframe start override.
                BPM can override internal timeframe start signal and use MGT generated one.
              comment: |
                write 1: overrides timeframe start. BPM uses external signal.
                write 0: normal operation. BPM uses internal generated signal.
              x-wbgen:
                clock: fofb_cc_clk_ram_reg_i
                type: BIT
    - reg:
        name: toa_ctl
        address: 0x00000004
        width: 32
        access: rw
        description: FOFB CC Time-of-Arrival configuration register
        comment: |
          FOFB CC Time-of-Arrival configuration register
        children:
          - field:
              name: rd_en
              range: 0
              description: enable FOFB CC TOA module for reading
              comment: |
                write 0: disable FOFB CC TOA module reading
                write 1: enable FOFB CC TOA module reading
              x-wbgen:
                type: BIT
                clock: fofb_cc_clk_ram_reg_i
          - field:
              name: rd_str
              range: 1
              description: Read next TOA address
              comment: |
                write 0: nothing
                write 1: read next TOA memory address. This bit auto-clears.
              x-wbgen:
                type: MONOSTABLE
                clock: fofb_cc_clk_ram_reg_i
    - reg:
        name: toa_data
        address: 0x00000008
        width: 32
        access: rw
        description: FOFB CC Time-of-Arrival data
        comment: |
          FOFB CC Time-of-Arrival data
        children:
          - field:
              name: val
              range: 31-0
              description: FOFB CC TOA data
              comment: |
                FOFB CC TOA data
              x-wbgen:
                type: SLV
                access_dev: WRITE_ONLY
                access_bus: READ_ONLY
                clock: fofb_cc_clk_sys_i

    - reg:
        name: rcb_ctl
        address: 0x0000000C
        width: 32
        access: rw
        description: FOFB CC Received Buffer configuration register
        comment: |
          FOFB CC Received Buffer configuration register
        children:
          - field:
              name: rd_en
              range: 0
              description: enable FOFB CC RCB module for reading
              comment: |
                write 0: disable FOFB CC RCB module reading
                write 1: enable FOFB CC RCB module reading
              x-wbgen:
                type: BIT
                clock: fofb_cc_clk_ram_reg_i
          - field:
              name: rd_str
              range: 1
              description: Read next RCB address
              comment: |
                write 0: nothing
                write 1: read next RCB memory address. This bit auto-clears.
              x-wbgen:
                type: MONOSTABLE
                clock: fofb_cc_clk_ram_reg_i
    - reg:
        name: rcb_data
        address: 0x00000010
        width: 32
        access: rw
        description: FOFB CC Received Buffer data
        comment: |
          FOFB CC Received Buffer data
        children:
          - field:
              name: val
              range: 31-0
              description: FOFB CC RCB data
              comment: |
                FOFB CC RCB data
              x-wbgen:
                type: SLV
                access_dev: WRITE_ONLY
                access_bus: READ_ONLY
                clock: fofb_cc_clk_sys_i

    - reg:
        name: xy_buff_ctl
        address: 0x00000014
        width: 32
        access: rw
        description: FOFB CC X/Y buffer configuration register
        comment: |
          FOFB CC X/Y buffer configuration register
        children:
          - field:
              name: unused
              range: 15-0
              description: unused
              comment: |
                Unused
              x-wbgen:
                type: SLV
                access_dev: WRITE_ONLY
                access_bus: READ_ONLY
                clock: fofb_cc_clk_sys_i
          - field:
              name: addr
              range: 31-16
              description: Read XY_BUFF address
              comment: |
                XY_BUFF memory address.
              x-wbgen:
                access_bus: READ_WRITE
                access_dev: READ_WRITE
                type: SLV
                load: LOAD_EXT
                clock: fofb_cc_clk_ram_reg_i
    - reg:
        name: xy_buff_data_msb
        address: 0x00000018
        width: 32
        access: rw
        description: FOFB CC X/Y buffer MSB
        comment: |
          FOFB CC X/Y buffer MSB
        children:
          - field:
              name: val
              range: 31-0
              description: FOFB CC XY_BUFF data MSB
              comment: |
                FOFB CC XY_BUFF data MSB
              x-wbgen:
                type: SLV
                access_dev: WRITE_ONLY
                access_bus: READ_ONLY
                clock: fofb_cc_clk_sys_i

    - reg:
        name: xy_buff_data_lsb
        address: 0x0000001C
        width: 32
        access: rw
        description: FOFB CC X/Y buffer LSB
        comment: |
          FOFB CC X/Y buffer LSB
        children:
          - field:
              name: val
              range: 31-0
              description: FOFB CC XY_BUFF data LSB
              comment: |
                FOFB CC XY_BUFF data LSB
              x-wbgen:
                type: SLV
                access_dev: WRITE_ONLY
                access_bus: READ_ONLY
                clock: fofb_cc_clk_sys_i

    - memory:
        name: ram_reg
        memsize: 8k
        address: 0x00002000
        description: FOFB CC RAM for register map
        comment: |
          Register map is hanlded inside the FOFC CC module, but the RAM to read/write
          to/from the signals are instantiated outside.
        align: True
        x-wbgen:
          kind: ram
          access_dev: READ_WRITE
          clock: fofb_cc_clk_ram_reg_i
        children:
          - reg:
              name: data
              width: 32
              access: rw
